* Friend's Analog State Variable Oscillator - target 30000.0 Hz
* R_int = 530.5 ohms (for C = 10nF)
* Auto-generated by CircuitForge kicad_pipeline.py
* Friend's design: AD824 op-amps, R7=100k (low damping), NO amplitude limiting
* Result: oscillates but clips at supply rails (~27Vpp, ~9.5V RMS)

.title Analog SVO Target=30000Hz

.include "C:/Users/bob43/Downloads/state variable Osc/State-Variable-Oscillator-MDAC/StateVarOsc/models/LM4562.lib"

* === Power Supply ===
VCC vcc 0 DC 15
VEE vee 0 DC -15

* ======================================================================
* SUMMING AMPLIFIER (U4 in friend's LTspice: AD824 -> LM4562)
* ======================================================================
* Friend's values: R5=10k feedback, R6=10k from LP, R7=100k from BP
* R7=100k gives very low damping (Q ~ R7/R5 = 10) compared to MDAC (22k, Q~2.2)
* Non-inverting input grounded (friend's JFET AGC fails to regulate,
* so the positive feedback path is effectively broken)
R5 hp sum_inv 10k
R6 lp sum_inv 10k
R7 bp sum_inv 100k
XU4 0 sum_inv vcc vee hp LM4562

* ======================================================================
* INTEGRATOR 1: HP -> BP (U2 in friend's LTspice: AD824 -> LM4562)
* ======================================================================
* Friend's design: fixed R/C (no MDAC), no Zener clamp
* R_int parameterized for target frequency: f = 1/(2*pi*R*C)
R1 hp int1_inv 530.5165
C1 int1_inv bp 1.00e-08
XU2 0 int1_inv vcc vee bp LM4562

* ======================================================================
* INTEGRATOR 2: BP -> LP (U1 in friend's LTspice: AD824 -> LM4562)
* ======================================================================
R3 bp int2_inv 530.5165
C2 int2_inv lp 1.00e-08
XU1 0 int2_inv vcc vee lp LM4562

* ======================================================================
* STARTUP AND LOAD
* ======================================================================
* Startup kick (same approach as MDAC oscillator)
Vkick kick_node 0 PULSE(0 0.1 0.1m 1n 1n 10u 1)
Rkick kick_node hp 100k

* Output load
RL bp 0 100k

* ======================================================================
* ANALYSIS
* ======================================================================
.tran 6.67e-07 0.5000 UIC

.control
tran 6.67e-07 0.5000 uic

* Frequency measurement (same method as MDAC oscillator)
meas tran t1 when v(bp)=0 rise=6000
meas tran t2 when v(bp)=0 rise=6001
let period = t2 - t1
let freq = 1 / period

* Amplitude measurement (last 20% of sim)
meas tran bp_pp pp v(bp) from=0.4000 to=0.5000
let bp_rms = bp_pp / (2 * 1.41421)
meas tran hp_pp pp v(hp) from=0.4000 to=0.5000
meas tran lp_pp pp v(lp) from=0.4000 to=0.5000

* Write results to file (identical format to MDAC oscillator)
* Use relative filename (ngspice cwd = sim_work dir)
echo "freq = $&freq" > analog_osc_30000Hz_results.txt
echo "bp_pp = $&bp_pp" >> analog_osc_30000Hz_results.txt
echo "bp_rms = $&bp_rms" >> analog_osc_30000Hz_results.txt
echo "hp_pp = $&hp_pp" >> analog_osc_30000Hz_results.txt
echo "lp_pp = $&lp_pp" >> analog_osc_30000Hz_results.txt

echo ""
echo "=== Results for Analog Osc target=30000Hz ==="
print freq
print bp_pp
print bp_rms
quit
.endc

.end
