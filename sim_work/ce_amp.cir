* Common Emitter BJT Amplifier
* Generated by kicad_pipeline.py

* Power supply
VCC VCC 0 12

* Input signal: 10mV @ 1kHz
VIN IN 0 SINE(0 10m 1k)

* Bias network
R1 VCC BASE 22k
R2 BASE 0 4.7k

* Input coupling
C1 IN BASE 1u

* Transistor
Q1 COLL BASE EMIT 0 2N3904

* Collector load
R3 VCC COLL 2.2k

* Emitter resistor + bypass
R4 EMIT 0 470
C3 EMIT 0 100u

* Output coupling + load
C2 COLL OUT 10u
RL OUT 0 10k

* BJT model
.model 2N3904 NPN(IS=1E-14 VAF=100 Bf=300 IKF=0.4 XTB=1.5 BR=4 CJC=4E-12 CJE=8E-12 RB=20 RC=0.1 RE=0.1 TR=250E-9 TF=350E-12 ITF=1 VTF=2 XTF=3)

* Simulation: transient analysis
.tran 1u 10m

.control
run
wrdata results.txt V(IN) V(OUT) V(COLL) V(BASE)
quit
.endc

.end
