* Signal Conditioner AC Analysis (LM741)
* Bode plot: gain and phase vs frequency

VCC VCC 0 12
VEE VEE 0 -12

* AC source: 1V amplitude for dB reading directly
VIN N_IN 0 AC 1

* Stage 1: Non-inverting amplifier (G=11)
R6 N_IN 0 100k
XU1 N_IN FB1 VCC VEE STAGE1 LM741_NS
R1 STAGE1 FB1 100k
R2 FB1 0 10k

* Sallen-Key LPF
R3 STAGE1 N1 10k
R4 N1 N2 10k
C3 N1 0 33n
C4 N2 FILTERED 15n

* Stage 2: Unity-gain buffer
XU2 N2 FILTERED VCC VEE FILTERED LM741_NS

* Load
R5 FILTERED 0 10k

* Model
.SUBCKT LM741_NS    1   2  99  50  28
*
*Features:
*Improved performance over industry standards
*Plug-in replacement for LM709,LM201,MC1439,748
*Input and output overload protection
*
****************INPUT STAGE**************
*
IOS 2 1 20N
*^Input offset current
R1 1 3 250K
R2 3 2 250K
I1 4 50 100U
R3 5 99 517
R4 6 99 517
Q1 5 2 4 QX
Q2 6 7 4 QX
*Fp2=2.55 MHz
C4 5 6 60.3614P
*
***********COMMON MODE EFFECT***********
*
I2 99 50 1.6MA
*^Quiescent supply current
EOS 7 1 POLY(1) 16 49 1E-3 1
*Input offset voltage.^
R8 99 49 40K
R9 49 50 40K
*
*********OUTPUT VOLTAGE LIMITING********
V2 99 8 1.63
D1 9 8 DX
D2 10 9 DX
V3 10 50 1.63
*
**************SECOND STAGE**************
*
EH 99 98 99 49 1
G1 98 9 5 6 2.1E-3
*Fp1=5 Hz
R5 98 9 95.493MEG
C3 98 9 333.33P
*
***************POLE STAGE***************
*
*Fp=30 MHz
G3 98 15 9 49 1E-6
R12 98 15 1MEG
C5 98 15 5.3052E-15
*
*********COMMON-MODE ZERO STAGE*********
*
*Fpcm=300 Hz
G4 98 16 3 49 3.1623E-8
L2 98 17 530.5M
R13 17 16 1K
*
**************OUTPUT STAGE**************
*
F6 50 99 POLY(1) V6 450U 1
E1 99 23 99 15 1
R16 24 23 25
D5 26 24 DX
V6 26 22 0.65V
R17 23 25 25
D6 25 27 DX
V7 22 27 0.65V
V5 22 21 0.18V
D4 21 15 DX
V4 20 22 0.18V
D3 15 20 DX
L3 22 28 100P
RL3 22 28 100K
*
***************MODELS USED**************
*
.MODEL DX D(IS=1E-15)
.MODEL QX NPN(BF=625)
*
.ENDS

* AC sweep: 10 Hz to 100 kHz, 50 points per decade
.ac dec 50 10 100k

.control
run
wrdata sig_cond_ac.txt vdb(FILTERED) vp(FILTERED) vdb(STAGE1) vp(STAGE1)
quit
.endc

.end
