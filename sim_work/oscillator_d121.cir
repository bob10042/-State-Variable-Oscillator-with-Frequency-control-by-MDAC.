* State Variable Oscillator - DAC code 121 (expected 1000.3 Hz)
* Auto-generated by CircuitForge kicad_pipeline.py

.title SVO Frequency Test D=121

.include "C:/Users/bob43/Downloads/state variable Osc/State-Variable-Oscillator-MDAC/StateVarOsc/models/LM4562.lib"
.include "C:/Users/bob43/Downloads/state variable Osc/State-Variable-Oscillator-MDAC/StateVarOsc/models/DAC7800.lib"

* === Power Supply ===
VCC vcc 0 DC 15
VEE vee 0 DC -15

* === MDAC Control Voltage ===
* DAC code 121: Vctrl = 121/4096 * 5.0 = 0.147705V
Vctrl ctrl_node 0 DC 0.147705

* === Summing Amplifier (U1a) ===
R_lp lp sum_inv 10k
R_bp bp sum_inv 22k
Rf_sum hp sum_inv 10k
XU1a 0 sum_inv vcc vee hp LM4562

* === Integrator 1: HP -> BP (via MDAC) ===
XDAC1 hp mdac1_out ctrl_node rfb1_nc DAC7800
Rint1 mdac1_out int1_inv 10k
Cint1 int1_inv bp 470p
R_damp1 int1_inv bp 100Meg
XU1b 0 int1_inv vcc vee bp LM4562

* Zener clamp on BP integrator
Dz1 z_mid1 int1_inv DZ09
Dz2 z_mid1 bp DZ09

* === Integrator 2: BP -> LP (via MDAC) ===
XDAC2 bp mdac2_out ctrl_node rfb2_nc DAC7800
Rint2 mdac2_out int2_inv 10k
Cint2 int2_inv lp 470p
R_damp2 int2_inv lp 100Meg
XU2a 0 int2_inv vcc vee lp LM4562

* Zener clamp on LP integrator
Dz3 z_mid2 int2_inv DZ09
Dz4 z_mid2 lp DZ09

* Zener model: BV=1.1V, threshold ~1.45V (tuned for ~1.03V RMS)
.model DZ09 D(Is=1e-14 BV=1.1 IBV=1e-3 N=1)

* === Startup kick pulse ===
Vkick kick_node 0 PULSE(0 0.1 0.1m 1n 1n 10u 1)
Rkick kick_node hp 100k

* === Output load ===
RL bp 0 100k

* === Analysis ===
.tran 1.00e-06 0.5000 UIC

.control
tran 1.00e-06 0.5000 uic

* Frequency measurement
meas tran t1 when v(bp)=0 rise=200
meas tran t2 when v(bp)=0 rise=201
let period = t2 - t1
let freq = 1 / period

* Amplitude measurement (last 20% of sim)
meas tran bp_pp pp v(bp) from=0.4000 to=0.5000
let bp_rms = bp_pp / (2 * 1.41421)
meas tran hp_pp pp v(hp) from=0.4000 to=0.5000
meas tran lp_pp pp v(lp) from=0.4000 to=0.5000

* Write results to file
echo "freq = $&freq" > oscillator_d121_results.txt
echo "bp_pp = $&bp_pp" >> oscillator_d121_results.txt
echo "bp_rms = $&bp_rms" >> oscillator_d121_results.txt
echo "hp_pp = $&hp_pp" >> oscillator_d121_results.txt
echo "lp_pp = $&lp_pp" >> oscillator_d121_results.txt

echo ""
echo "=== Results for D=121 ==="
print freq
print bp_pp
print bp_rms
quit
.endc

.end
