* Audio Amplifier - LTspice Educational Example
* 3-stage BJT: diff pair + VAS + push-pull output
* Converted to ngspice by CircuitForge pipeline

* === Power Supplies ===
V1 VCC 0 10
V2 VEE 0 -10

* === Input Signal ===
V3 IN 0 SINE(0 0.7 1k)
* V4 is AC stimulus (0V DC = short for transient)
V4 OUT FB DC 0

* === Stage 1: Differential Pair ===
R1 Q1B IN 5k
Q1 Q1C Q1B TAIL 0 Q2N3904
Q2 VCC Q2B TAIL 0 Q2N3904
R2 VCC Q1C 200
R3 TAIL VEE 1k

* Q2 base: feedback + bias
R6 Q2B 0 5k
R7 FB Q2B 50k

* === Stage 2: Active Load + VAS ===
* Interstage coupling: Q1C -> R4 -> R5 -> Q3 base
R4 FB_MID Q1C 9k
C1 FB_MID Q1C 10p
R5 Q3B FB_MID 1k

* Q3 PNP active load
Q3 VAS Q3B Q3E 0 Q2N3906
R8 VCC Q3E 100
C2 VAS Q3B 100p

* Q4 voltage amplification stage
Q4 VAS Q4B Q4E 0 Q2N3904
R9 VAS Q4B 2k
R10 Q4B Q4E 1k
R11 Q4E VEE 5k

* Bootstrap
C3 VAS Q4E 1m

* === Stage 3: Quasi-Complementary Output ===
* Upper: Q5 driver -> Q7 output (both NPN)
Q5 VCC VAS Q5E 0 Q2N3904
Q7 VCC Q5E OUT 0 Q2N2219A
R12 Q5E OUT 1k

* Lower: Q6 PNP driver -> Q8 NPN output
Q6 Q6C Q4E OUT 0 Q2N3906
Q8 OUT Q6C VEE 0 Q2N2219A
R13 Q6C VEE 1k

* === Load ===
R14 OUT 0 8

* === BJT Models ===
.model Q2N3904 NPN(IS=1E-14 VAF=100 Bf=300 IKF=0.4 XTB=1.5
+ BR=4 CJC=4E-12 CJE=8E-12 RB=20 RC=0.1 RE=0.1
+ TR=250E-9 TF=350E-12 ITF=1 VTF=2 XTF=3)

.model Q2N3906 PNP(IS=1E-14 VAF=100 Bf=180 IKF=0.4 XTB=1.5
+ BR=4 CJC=4.5E-12 CJE=10E-12 RB=20 RC=0.1 RE=0.1
+ TR=250E-9 TF=350E-12 ITF=1 VTF=2 XTF=3)

.model Q2N2219A NPN(IS=14.34E-15 VAF=74.03 Bf=255.9 IKF=0.2847
+ XTB=1.5 BR=6.092 CJC=7.306E-12 CJE=22.01E-12 RB=10
+ RC=0.1 RE=0.1 TR=46.91E-9 TF=411.1E-12 ITF=0.6 VTF=1.7 XTF=3)

* === Simulation ===
.tran 1u 10m
.options maxstep=10u

.control
run
wrdata audioamp_results.txt V(IN) V(OUT) V(VAS) V(Q4E)
quit
.endc

.end
